* TEMPORARY probe: both-end currents vs bone load (1k..130k), bus 12V and 8V.
* R_BONE is behavioural and swept by .dc so the solve continues along the physical
* branch through the compliance knee. The bus voltage is the .step axis.
.include D:\Shared\LPspice_circuit\.ltspice-mcp\runs\exp_bonesweep_1790057410_8309f598\staged\bonesweep\root-0\ltspice\models\OPAx333.LIB
.include D:\Shared\LPspice_circuit\.ltspice-mcp\runs\exp_bonesweep_1790057410_8309f598\staged\bonesweep\root-0\ltspice\models\2N7002_DIODES.lib
.include D:\Shared\LPspice_circuit\.ltspice-mcp\runs\exp_bonesweep_1790057410_8309f598\staged\bonesweep\root-0\ltspice\models\APPROX_NOT_VENDOR.lib
.include D:\Shared\LPspice_circuit\.ltspice-mcp\runs\exp_bonesweep_1790057410_8309f598\staged\bonesweep\root-0\ltspice\inc\solver.inc
.include D:\Shared\LPspice_circuit\.ltspice-mcp\runs\exp_bonesweep_1790057410_8309f598\staged\bonesweep\root-0\ltspice\inc\power.inc
.include D:\Shared\LPspice_circuit\.ltspice-mcp\runs\exp_bonesweep_1790057410_8309f598\staged\bonesweep\root-0\ltspice\inc\sink.inc
C5 V_BUS PGND 1u
C6 V_BUS PGND 100n
VBUS V_BUS PGND {VB}
VCTRL CTRL 0 0
R_BONE BONE_P BONE_N R={1k + V(CTRL)*129k}
.param VB=12
.step param VB list 12 8
.dc VCTRL 0 1 0.005
.save V(V_BUS) V(BONE_P) V(BONE_N) V(V3V3) V(I_SENSE) V(OUTA) I(R_BONE) I(VBUS) I(R1) I(R10)
.options plotwinsize=0 numdgt=15
.end
