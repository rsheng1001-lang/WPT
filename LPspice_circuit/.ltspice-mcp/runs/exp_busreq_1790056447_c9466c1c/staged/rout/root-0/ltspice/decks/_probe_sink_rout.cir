* TEMPORARY probe: sink output resistance from the compliance curve.
* Load is a behavioural resistor swept 1k..100k; I(R_BONE) and V(BONE_N) are
* written at 15 significant digits so dV/dI can be resolved inside the
* regulating region. Ideal rails: this measures the sink, not the regulators.
.include D:\Shared\LPspice_circuit\.ltspice-mcp\runs\exp_busreq_1790056447_c9466c1c\staged\rout\root-0\ltspice\models\OPAx333.LIB
.include D:\Shared\LPspice_circuit\.ltspice-mcp\runs\exp_busreq_1790056447_c9466c1c\staged\rout\root-0\ltspice\models\2N7002_DIODES.lib
.include D:\Shared\LPspice_circuit\.ltspice-mcp\runs\exp_busreq_1790056447_c9466c1c\staged\rout\root-0\ltspice\inc\solver.inc
.include D:\Shared\LPspice_circuit\.ltspice-mcp\runs\exp_busreq_1790056447_c9466c1c\staged\rout\root-0\ltspice\inc\sink.inc
V8 BONE_P 0 8.0016
V33 V3V3 0 3.3
VCTRL CTRL 0 0
R_BONE BONE_P BONE_N R={1k + V(CTRL)*99k}
.dc VCTRL 0 1 0.002
.save V(BONE_P) V(BONE_N) V(I_SET) V(I_SENSE) I(R_BONE) I(R10)
.options plotwinsize=0 numdgt=15
.end
