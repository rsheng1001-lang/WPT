* Full downstream DC feasibility, V_BUS 4V..16V. Supplies now come from the
* surrogate regulators in power.inc: the OPAx333 and 2N7002 are manufacturer
* models, the two LDOs and the TVS are USER-CREATED APPROXIMATIONS and this
* deck therefore qualifies connectivity and DC operating regions only.
* RLOAD is a test resistor, not a measured bone/electrode impedance.
.include D:\Shared\LPspice_circuit\.ltspice-mcp\runs\exp_full-bus-dc_1790056339_d8327a32\staged\full_bus_dc\root-0\ltspice\models\OPAx333.LIB
.include D:\Shared\LPspice_circuit\.ltspice-mcp\runs\exp_full-bus-dc_1790056339_d8327a32\staged\full_bus_dc\root-0\ltspice\models\2N7002_DIODES.lib
.include D:\Shared\LPspice_circuit\.ltspice-mcp\runs\exp_full-bus-dc_1790056339_d8327a32\staged\full_bus_dc\root-0\ltspice\models\APPROX_NOT_VENDOR.lib
.include D:\Shared\LPspice_circuit\.ltspice-mcp\runs\exp_full-bus-dc_1790056339_d8327a32\staged\full_bus_dc\root-0\ltspice\inc\solver.inc
.include D:\Shared\LPspice_circuit\.ltspice-mcp\runs\exp_full-bus-dc_1790056339_d8327a32\staged\full_bus_dc\root-0\ltspice\inc\power.inc
.include D:\Shared\LPspice_circuit\.ltspice-mcp\runs\exp_full-bus-dc_1790056339_d8327a32\staged\full_bus_dc\root-0\ltspice\inc\core.inc
C5 V_BUS PGND 1u
C6 V_BUS PGND 100n
VBUS V_BUS PGND 12
.param RLOAD=10k
.dc VBUS 4 16 0.25
.save V(V_BUS) V(BONE_P) V(V3V3) V(I_SET) V(I_SENSE) V(OUTA) V(BONE_N) I(R_BONE) I(VBUS)
.options plotwinsize=0 numdgt=7
.end
