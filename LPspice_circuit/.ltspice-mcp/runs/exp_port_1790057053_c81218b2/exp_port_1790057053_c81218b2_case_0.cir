* TEMPORARY probe: I_BUS(V_BUS) port characteristic of everything downstream of
* the rectifier, for a lumped Simulink load model. Sweep runs 16V -> 0V so the
* whole curve stays on the physical solution branch.
.include D:\Shared\LPspice_circuit\.ltspice-mcp\runs\exp_port_1790057053_c81218b2\staged\port\root-0\ltspice\models\OPAx333.LIB
.include D:\Shared\LPspice_circuit\.ltspice-mcp\runs\exp_port_1790057053_c81218b2\staged\port\root-0\ltspice\models\2N7002_DIODES.lib
.include D:\Shared\LPspice_circuit\.ltspice-mcp\runs\exp_port_1790057053_c81218b2\staged\port\root-0\ltspice\models\APPROX_NOT_VENDOR.lib
.include D:\Shared\LPspice_circuit\.ltspice-mcp\runs\exp_port_1790057053_c81218b2\staged\port\root-0\ltspice\inc\solver.inc
.include D:\Shared\LPspice_circuit\.ltspice-mcp\runs\exp_port_1790057053_c81218b2\staged\port\root-0\ltspice\inc\power.inc
.include D:\Shared\LPspice_circuit\.ltspice-mcp\runs\exp_port_1790057053_c81218b2\staged\port\root-0\ltspice\inc\core.inc
VBUS V_BUS PGND 12
.param RLOAD=10k
.dc VBUS 16 0 -0.02
.save V(V_BUS) V(BONE_P) V(V3V3) V(BONE_N) I(R_BONE) I(VBUS) I(R1) I(R4)
.options plotwinsize=0 numdgt=15
.end
