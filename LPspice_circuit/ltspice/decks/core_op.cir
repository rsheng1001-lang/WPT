* Manufacturer-model current sink; ideal rail TEST FIXTURE, not a regulator simulation.
* RLOAD is a test resistor, not a measured bone/electrode impedance.
* Loads are limited to the range where a cold .op solve is trustworthy. Above
* ~66k the OPAx333 macro-model's switch network has competing DC solutions and
* a cold .op lands on an absurd one (V(OUTA) far outside 0..3.3V); the
* compliance edge is measured by continuation in core_compliance.cir instead.
.include ../models/OPAx333.LIB
.include ../models/2N7002_DIODES.lib
.include ../inc/solver.inc
.include ../inc/core.inc
V8 BONE_P 0 8.0016
V33 V3V3 0 3.3
.param RLOAD=10k
.step param RLOAD list 1k 10k 50k 65k
.op
.meas op I_BONE param I(R_BONE)
.meas op I_SENSE_R param I(R10)
.meas op V_ISET param V(I_SET)
.meas op V_SENSE param V(I_SENSE)
.meas op V_GATE param V(STIM_GATE)
.meas op V_OUTA param V(OUTA)
.meas op V_BONE param V(BONE_P,BONE_N)
.meas op V_DRAIN param V(BONE_N)
.options plotwinsize=0 numdgt=7
.end
